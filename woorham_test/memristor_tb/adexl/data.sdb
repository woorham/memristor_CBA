ADE simulation setup
Run mode: Single Run, Sweeps and Corners
Tests:
  woorham_test:memristor_tb:1: woorham_test/memristor_tb/schematic, simulator spectre
Global variables:
  wireopt = 8
  a0 = 0.4
  Beta = 0.8
  Ea = 0.6
  g0 = 0.25
  gamma0 = 16
  Kclip = 50
  maxGap = 1.7
  minGap = 0.01
  smoothing = 1e-8
  tox = 12
  V0 = 0.25
  Vel0 = 10
  R0 = 100k
  Rmax = 1e12
  vdd = 2
