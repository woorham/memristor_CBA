ADE simulation setup
Run mode: Single Run, Sweeps and Corners
Tests:
  woorham_test:ts_tb:1: woorham_test/ts_tb/schematic, simulator spectre
    Outputs: /V0/MINUS; waveVsWave(?x v("/t" ?result "tran") ?y i("/V0/MINUS" ?result "tran"))
Global variables:
  wireopt = 8
  vdd = 1
  an = 1
  Imin = 1e-12
  N = 20
  Imax = 2m
  Rmax = 1e12
  Vfit = 1.5
