ADE simulation setup
Run mode: Single Run, Sweeps and Corners
Tests:
  woorham_test:memristor_tb:1: woorham_test/1s1r_tb/schematic, simulator spectre
Global variables:
  wireopt = 8
  a0 = 0.4
  Beta = 0.8
  Ea = 0.6
  g0 = 0.25
  gamma0 = 16
  Kclip = 50
  maxGap = 1.7
  minGap = 0.01
  smoothing = 1e-8
  tox = 4
  V0 = 0.25
  Vel0 = 10
  R0 = 20k
  Rmax = 1e12
  vdd = 2
  an = 5
  Imax = 100m
  Imin = 1e-12
  N = 12
  r_wire = 0
  c_mem = 0.1f
  c_ts = 0
  Vfit = 4.5
