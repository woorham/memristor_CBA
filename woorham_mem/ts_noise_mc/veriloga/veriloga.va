// VerilogA for woorham_test, memristor, veriloga

`include "constants.vams"
`include "disciplines.vams"

module ts_noise_mc(t, b);
inout t, b;
electrical t, b;
parameter real an = 0.01 from (0:inf);
parameter real N = 20 from (0:inf);
parameter real Vfit = 2 from (0:inf);
parameter real Imax = 1e-2 from (0:inf);
parameter real Rmax = 1e12 from (0:inf);

//parameter integer mySeed = 0 from [0:inf);
(* cds_inherited_parameter *) parameter real sigma_ts = 0.0;

real R;
real R_ts;

analog begin
	R_ts = (1 / an / (abs(V(t, b)/Vfit)+0) ** (N-1)) * (1.0 + sigma_ts);
	R = R_ts * Rmax / (R_ts + Rmax);
	if (V(t, b) > 0)
		I(t, b) <+ (V(t, b)/R) * Imax / ((V(t, b)/R) + Imax);
	else
		I(t, b) <+ -(V(t, b)/R) * Imax / ((V(t, b)/R) - Imax);
	I(t, b) <+ white_noise(4*`P_K*$temperature/R);
end
endmodule
