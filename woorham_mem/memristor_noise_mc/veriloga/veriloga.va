// VerilogA for woorham_test, memristor, veriloga

`include "constants.vams"
`include "disciplines.vams"

module memristor_noise_mc(t, b);
inout t, b;
electrical t, b, nGap;
parameter real g0 = 0.25 from (0:inf);
parameter real V0 = 0.25 from (0:inf);
parameter real Vel0 = 10 from (0:inf);
parameter real I0 = 1e-5 from (0:inf);
parameter real Beta = 0.8 from (0:inf);
parameter real gamma0 = 16 from (0:inf);
parameter real Ea = 0.6 from (0:inf);
parameter real a0 = 0.4 from (0:inf);
parameter real tox = 4 from (0:inf);

parameter real maxGap = 1.7 from (0:inf);
parameter real minGap = 0.0 from (0:inf);

parameter real smoothing = 1e-8 from (0:inf);
parameter real Rmax = 1e12 from (0:inf);
parameter real Kclip = 50 from (0:inf);

parameter real fc_flicker = 1e6 from (0:inf);
parameter real Rth_shot = 1e9 from (0:inf);
parameter integer use_shot_noise = 1 from [0:1];
(* cds_inherited_parameter *) parameter real sigma_mem = 0.0;

real Gap, ddt_gap, Gamma, Fw1, Fw2, Rmem, R;
real clip_minGap, clip_maxGap;

analog function real smoothstep;
	input x, smoothing;
	real x, smoothing;
	begin
		smoothstep = 0.5*(x/sqrt(x*x + smoothing)+1);
	end
endfunction // smoothstep

analog begin
	Gap = V(nGap, b);
	Rmem = (V(t, b) / I0 / limexp(-Gap/g0) / sinh(V(t, b)/V0))*(1.0+sigma_mem);
	R = abs(Rmem*Rmax/(Rmem+Rmax));
	I(t, b) <+ V(t, b)/R;
	Gamma = gamma0 - Beta * pow(Gap, 3);
	ddt_gap = -Vel0 * exp(-Ea/$vt) * sinh(V(t, b) * Gamma*a0/tox/$vt);
	Fw1 = smoothstep(minGap-Gap, smoothing);
	Fw2 = smoothstep(Gap-maxGap, smoothing);
	clip_minGap = (limexp(Kclip*(minGap-Gap)) - ddt_gap) * Fw1;
	clip_maxGap = (-limexp(Kclip*(Gap-maxGap)) - ddt_gap) * Fw2;

	I(nGap, b) <+ ddt_gap + clip_minGap + clip_maxGap;
	I(nGap, b) <+ ddt(-1e-9*Gap);
	I(t, b) <+ white_noise(4*`P_K*$temperature/R);
	I(t, b) <+ flicker_noise(4*`P_K*$temperature/R*fc_flicker, 1, "flicker");
	if (use_shot_noise == 1)
		if (R > Rth_shot)
			I(t, b) <+ white_noise(2*1.6e-19*I(t, b));
end
endmodule
